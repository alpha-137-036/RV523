.subckt AOI2111 Y A1 A2 B1 C1 D1 VDD VSS
 XN1 A1 VSS sndA1 RV523_NMOS
 XN2 A2 sndA1 Y RV523_NMOS
 XN3 B1 VSS Y RV523_NMOS
 XN4 C1 VSS Y RV523_NMOS
 XN5 D1 VSS Y RV523_NMOS
 XP1 A1 VDD pndA RV523_PMOS
 XP2 A2 VDD pndA RV523_PMOS
 XP3 B1 pndA pndB RV523_PMOS
 XP4 C1 pndB pndC RV523_PMOS
 XP5 D1 pndC Y RV523_PMOS
.ends
