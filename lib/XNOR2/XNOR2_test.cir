* Main ngspice simulation file

.include "../RV523_global.sp"
.include "XNOR2.ckt"
.include "pwl_Inputs.sp"

VDD VDD 0 {vdd}

* Load capacitor on output
Cload Y 0 30p

XU1 Y A B VDD 0 XNOR2

.TRAN 0.1ns 2600ns

* Simulation control
.control
    run
    write XNOR2.raw
    quit
.endc
.END
