.subckt XNOR2 Y A B VDD VSS
 XN1 A VSS sndNA RV523_NMOS
 XN2 B sndNA inand RV523_NMOS
 XN3 A VSS nmid RV523_NMOS
 XN4 B VSS nmid RV523_NMOS
 XN5 inand nmid Y RV523_NMOS
 XP1 A VDD inand RV523_PMOS
 XP2 B VDD inand RV523_PMOS
 XP3 A VDD sndPA RV523_PMOS
 XP4 B sndPA Y RV523_PMOS
 XP5 inand VDD Y RV523_PMOS
.ends
