.subckt NOR3B Y A1 A2 A3_N VDD VSS
 Xnor3.N1 A1 VSS Y RV523_NMOS
 Xnor3.N2 A2 VSS Y RV523_NMOS
 Xnor3.N3 A3 VSS Y RV523_NMOS
 Xnor3.P1 A1 nor3.int1 Y RV523_PMOS
 Xnor3.P2 A2 nor3.int2 nor3.int1 RV523_PMOS
 Xnor3.P3 A3 VDD nor3.int2 RV523_PMOS
 Xnot1.N1 A3_N VSS A3 RV523_NMOS
 Xnot1.P1 A3_N VDD A3 RV523_PMOS
.ends
