.subckt OAI221 Y A1 A2 B1 B2 C VDD VSS
 XN1 A1 VSS intNA RV523_NMOS
 XN2 A2 VSS intNA RV523_NMOS
 XN3 B1 intNA intNB RV523_NMOS
 XN4 B2 intNA intNB RV523_NMOS
 XN5 C intNB Y RV523_NMOS
 XP1 A1 VDD intPA RV523_PMOS
 XP2 A2 intPA Y RV523_PMOS
 XP3 B1 VDD intPB RV523_PMOS
 XP4 B2 intPB Y RV523_PMOS
 XP5 C VDD Y RV523_PMOS
.ends
