.subckt OAI222 Y A1 A2 B1 B2 C1 C2 VDD VSS
 XN1 A1 VSS intNA RV523_NMOS
 XN2 A2 VSS intNA RV523_NMOS
 XN3 B1 intNA intNB RV523_NMOS
 XN4 B2 intNA intNB RV523_NMOS
 XN5 C1 intNB Y RV523_NMOS
 XN6 C2 intNB Y RV523_NMOS
 XP1 A1 VDD intPA RV523_PMOS
 XP2 A2 intPA Y RV523_PMOS
 XP3 B1 VDD intPB RV523_PMOS
 XP4 B2 intPB Y RV523_PMOS
 XP5 C1 VDD intPC RV523_PMOS
 XP6 C2 intPC Y RV523_PMOS
.ends
