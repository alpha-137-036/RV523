.inc "2SK3019.sub"
* .inc "2n7002T.sub"
* SOT-523 pin order 1=G, 2=D, 3=S
.SUBCKT RV523_NMOS G S D
    * 2SK3019 model has pin order D  G  S
    X1 D G S _2SK3019
	* X1 D G S N7002T
.ENDS
