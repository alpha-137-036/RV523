.subckt AOI311 Y A1 A2 A3 B1 C1 VDD VSS
 XN1 A1 VSS intA1 RV523_NMOS
 XN2 A2 intA1 intA2 RV523_NMOS
 XN3 A3 intA2 Y RV523_NMOS
 XN4 B1 VSS Y RV523_NMOS
 XN5 C1 VSS Y RV523_NMOS
 XP1 A1 intPA Y RV523_PMOS
 XP2 A2 intPA Y RV523_PMOS
 XP3 A3 intPA Y RV523_PMOS
 XP4 B1 intPB intPA RV523_PMOS
 XP5 C1 VDD intPB RV523_PMOS
.ends
