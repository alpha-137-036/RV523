.subckt XOR2 Y A B VDD VSS
 XN1 A VSS inor RV523_NMOS
 XN2 B VSS inor RV523_NMOS
 XN3 A VSS sndNA RV523_NMOS
 XN4 B sndNA Y RV523_NMOS
 XN5 inor VSS Y RV523_NMOS
 XP1 A VDD sndPA RV523_PMOS
 XP2 B sndPA inor RV523_PMOS
 XP3 A VDD pmid RV523_PMOS
 XP4 B VDD pmid RV523_PMOS
 XP5 inor pmid Y RV523_PMOS
.ends
