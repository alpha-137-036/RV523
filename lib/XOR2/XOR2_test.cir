* Main ngspice simulation file

.include "../RV523_global.sp"
.include "XOR2.ckt"
.include "pwl_Inputs.sp"

VDD VDD 0 {vdd}

* Load capacitor on output
Cload Y 0 30p

XU1 Y A B VDD 0 XOR2

.TRAN 0.1ns 2600ns

* Simulation control
.control
    run
    write XOR2.raw
    quit
.endc
.END
