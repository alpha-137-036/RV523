.subckt NAND4B Y A1_N A2 A3 A4 VDD VSS
 Xnand4.N1 A1 VSS nand4.int1 RV523_NMOS
 Xnand4.N2 A2 nand4.int1 nand4.int2 RV523_NMOS
 Xnand4.N3 A3 nand4.int2 nand4.int3 RV523_NMOS
 Xnand4.N4 A4 nand4.int3 Y RV523_NMOS
 Xnand4.P1 A1 VDD Y RV523_PMOS
 Xnand4.P2 A2 VDD Y RV523_PMOS
 Xnand4.P3 A3 VDD Y RV523_PMOS
 Xnand4.P4 A4 VDD Y RV523_PMOS
 Xnot1.N1 A1_N VSS A1 RV523_NMOS
 Xnot1.P1 A1_N VDD A1 RV523_PMOS
.ends
