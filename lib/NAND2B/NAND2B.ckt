.subckt NAND2B Y A_N B VDD VSS
 XN1 A_N VSS A RV523_NMOS
 XN2 A sndA Y RV523_NMOS
 XN3 B VSS sndA RV523_NMOS
 XP1 A_N VDD A RV523_PMOS
 XP2 A VDD Y RV523_PMOS
 XP3 B VDD Y RV523_PMOS
.ends
