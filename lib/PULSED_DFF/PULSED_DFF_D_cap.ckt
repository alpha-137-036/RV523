.title Measure input capacitance of CK pin of a DFF
* ---------------------------------------------------------
.include ../Transistors/RV523_NMOS.ckt
.include ../Transistors/RV523_PMOS.ckt
.include PULSED_DFF.ckt

.options TEMP = 25C
.options TNOM = 25C
.options method=gear

.param vdd=3.3V

* Power supplies
VDD VDD 0 {vdd}
VSS VSS 0 0

* Bias the CK input to a valid logic level
VD CK  0  0

* Bias Q output (optional, depends on your DFF topology)
* Some DFFs require Q to be pre-biased to avoid floating nodes
VQ  Q  0  0

* AC source on D pin
Vin D 0 DC 0 AC 1

* Instantiate the DFF
* Replace pin order with your actual subckt definition
Xdut Q nQ D CK VDD VSS PULSED_DFF

Rload Q 0 100k

* Small-signal AC analysis at 1 MHz
.ac lin 1 1e6 1e6

.control
    run
    let D_cap = abs(imag(I(Vin))) / (2 * 3.1415926535 * 1e6)
    print D_cap
    exit
.endc

* Measure imaginary current into CK pin
* ngspice convention: current flows from positive terminal into device
* .measure ac ICK imag(I(VCK))

* Compute capacitance: C = Im(I) / (2*pi*f)
* .measure ac CCK param='ICK / (2 * 3.1415926535)'

.end
