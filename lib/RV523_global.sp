.inc "Transistors/RV523_NMOS.ckt"
.inc "Transistors/RV523_PMOS.ckt"

.PARAM vdd=3.3V
