.include "../NOT/NOT.ckt"
.include "../NAND2/NAND2.ckt"
.include "../D_LATCH/D_LATCH.ckt"

.subckt PULSE_GENERATOR P nP CK VDD VSS
    R1 CK D 330
    C1 D 0 100p
    X1 nD D VDD VSS NOT
    XN10 P0 CK nD VDD VSS NAND2
    XN20 nP0 P0 VDD VSS NOT
    XN21 P nP0 VDD VSS NOT
    XN22 nP P0 VDD VSS NOT
.ends

.subckt D_LATCH_ASYNC_RESET Q nQ D RN EN nEN VDD VSS
* delay input
 R1 D1 D 330
 C1 D1 VSS 100p
 XNOT1.N1 D1 VSS NOT1.intN RV523_NMOS
 XNOT1.N2 EN NOT1.intN nQ RV523_NMOS
 XNOT1.P1 D1 VDD NOT1.intP RV523_PMOS
 XNOT1.P2 nEN NOT1.intP nQ RV523_PMOS
 XNOT2.N1 nQ VSS Q RV523_NMOS
 XNOT2.P1 nQ VDD Q RV523_PMOS
 XNOT3.N0 RN VSS NOT3.intN0 RV523_NMOS
 XNOT3.N1 Q NOT3.intN0 NOT3.intN RV523_NMOS
 XNOT3.N2 nEN NOT3.intN nQ RV523_NMOS
 XNOT3.P0 RN VDD nQ RV523_PMOS
 XNOT3.P1 Q VDD NOT3.intP RV523_PMOS
 XNOT3.P2 EN NOT3.intP nQ RV523_PMOS
.ends

.subckt PULSED_DFF_ASYNC_RESET Q nQ D RN CK VDD VSS
    XU1 P nP CK VDD VSS PULSE_GENERATOR
    XU2 Q nQ D RN nP P VDD VSS D_LATCH_ASYNC_RESET
.ends
.END
