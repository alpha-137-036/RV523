.subckt OAI31 Y A1 A2 A3 B VDD VSS
 XN1 A1 VSS intN RV523_NMOS
 XN2 A2 VSS intN RV523_NMOS
 XN3 A3 VSS intN RV523_NMOS
 XN4 B intN Y RV523_NMOS
 XP1 A1 VDD intPA1 RV523_PMOS
 XP2 A2 intPA1 intPA2 RV523_PMOS
 XP3 A3 intPA2 Y RV523_PMOS
 XP4 B VDD Y RV523_PMOS
.ends
